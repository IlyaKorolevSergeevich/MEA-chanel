* Real Chopper Switch Test with Auto-Measurement
.lib /home/elliotx/pdk/share/pdk/sky130A/libs.tech/ngspice/sky130.lib.spice tt

* ВХОД
VIN in 0 0.9

* ТАКТЫ (200 кГц)
VCLK clk 0 pulse(0 1.8 1u 1n 1n 2.5u 5u)
VCLKD clkd 0 pulse(1.8 0 1u 1n 1n 2.5u 5u)

* ОСНОВНОЙ КЛЮЧ (без компенсации)
XSW in clk out 0 sky130_fd_pr__nfet_01v8 W=1 L=0.15 nf=1
Cout out 0 1p

* СХЕМА С КОМПЕНСАЦИЕЙ (Dummy Switch)
XDUM in clkd out_dummy 0 sky130_fd_pr__nfet_01v8 W=0.5 L=0.15 nf=1
XSW2 in clk out_dummy 0 sky130_fd_pr__nfet_01v8 W=1 L=0.15 nf=1
Cout_dummy out_dummy 0 1p

.control
tran 1n 8u
* Измеряем напряжение за 0.1 мкс ДО выключения (3.4 мкс) и ПОСЛЕ (3.6 мкс)
meas tran v_out_before find v(out) at=3.4u
meas tran v_out_after find v(out) at=3.6u
meas tran v_dummy_before find v(out_dummy) at=3.4u
meas tran v_dummy_after find v(out_dummy) at=3.6u
.endc
.end
